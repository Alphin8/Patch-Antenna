# Ansys Electronics Desktop project, version 2022.1
materials:
  vacuum: permittivity=1
  FR4_epoxy: permittivity=4.4 dielectric_loss_tangent=0.02
  pec: conductivity=1e+30

design HFSSDesign1 (HFSS, DrivenModal, model units mm)
variables:
  l = 28.407424mm  # optimise 14.7212mm..49.1636mm
  w = 38.0363mm
  h = 1.6mm
  lg = 6*h+l
  wg = 6*h+w
  fx = 10.56019mm  # optimise 4.89955mm..14.69865mm
  fy = 0mm
  rout = (6.35/2) mm
  rin = (0.97/2) mm
  rd = (4.59/2) mm
  hc = 3.5mm
geometry:
  patch = rectangle(corner=(-l/2, -w/2, 0mm), x_size=l, y_size=w)
  Box1 [FR4_epoxy] = box(corner=(-lg/2, -wg/2, 0mm), size=(lg, wg, -h))
  ground = rectangle(corner=(-lg/2, -wg/2, -h), x_size=lg, y_size=wg)
  pin [pec] = cylinder(axis=Z, base_centre=(fx, fy, 0), radius=rin, height=-hc-h)
  dielectric [vacuum] = cylinder(axis=Z, base_centre=(fx, fy, -h), radius=rd, height=-hc)
  Cylinder3 = cylinder(axis=Z, base_centre=(fx, fy, 0), radius=rin, height=-hc-h)
  outer [pec] = cylinder(axis=Z, base_centre=(fx, fy, -h), radius=rout, height=-hc)
  Cylinder5 = cylinder(axis=Z, base_centre=(fx, fy, -h), radius=rd, height=-hc)
  dielectric.subtract(Cylinder3)
  outer.subtract(Cylinder5)
  RadiatingSurface [vacuum] = region(absolute_offset=41.666667mm on all sides)
  Circle1 = circle(normal=Z, centre=(fx, fy, -h), radius=rout)
  ground.subtract(Circle1)
  pin1 = cylinder(axis=Z, base_centre=(fx, fy, 0), radius=rin, height=-hc-h)
  Box1.subtract(pin1)
  pecCap1 [pec] = object_from(dielectric.edge(1 of 2))
  pecCap1.thicken(0.94mm)
boundaries and excitations:
  PerfE1: Perfect E Objects=ground
  PerfE2: Perfect E Objects=patch
  Open1: Radiation Objects=RadiatingSurface
  Rad1: Radiation Faces=pin.face(3 of 3)
  PerfE3: Perfect E Objects=[outer, pin]
  1: Wave Port Faces=dielectric.face(2 of 3) pin.face(2 of 3) NumModes=1 Modes{Mode1{IntLine{(10.56019, 0, -5.1) -> (11527.127mm, 2070.6767mm, -5100mm)} CharImp=Zpi}}
  reference conductors: outer
setups:
  Setup1: HfssDriven Frequency=2.4GHz MaxDeltaS=0.02 MaximumPasses=20 MinimumPasses=1 MinimumConvergedPasses=1 PercentRefinement=30 BasisOrder=1 PortAccuracy=2 DrivenSolverType="Direct Solver"
    sweep Sweep: 1.5GHz to 3.5GHz step 0.025GHz; Type=Fast SaveFields
source amplitudes:
  1:1: 1W 0deg
radiation setups:
  3D: Infinite Sphere Theta=0deg..180deg step 2deg Phi=-180deg..180deg step 2deg
  Elevation: Infinite Sphere Theta=-180deg..180deg step 1deg Phi=0deg..90deg step 90deg
  Azimuth: Infinite Sphere Theta=90deg..90deg step 0deg Phi=-180deg..180deg step 1deg
  Infinite Sphere1: Infinite Sphere Theta=0deg..360deg step 3deg Phi=0deg..360deg step 10
  antenna array: ParametricArray DesignFrequency=2.4GHz LayoutType=1 CenterCellX=0mm CenterCellY=0mm CenterCellZ=0mm SpecifyDesignInWavelength WidthSpacing=6.2456762mm WidthSpacingInWavelength=0.05 Width=49.96541mm WidthInWavelength=0.4 LengthSpacing=6.2456762mm LengthSpacingInWavelength=0.05 Length=37.47405725mm LengthInWavelength=0.3 SymmetryType=0 StaggerAngle=0deg StaggerType=0 UDirnX=1 UDirnY=0 UDirnZ=0 VDirnX=0 VDirnY=1 VDirnZ=0 WeightType=3 EdgeTaperX_db=-200 CosineExp=1 DifferentialType=0 Behavior=UseScanAngle ScanAnglePhi=0deg ScanAngleTheta=0deg UDirnPhaseShift=0deg VDirnPhaseShift=0deg
reports:
  S Parameter Plot 1: dB(S(1,1)) vs Freq on Setup1 : Sweep; markers m1 at 2.425GHz, m2 at 2.3624855GHz
  Gain Plot 1: dB(GainTotal) vs Phi, Theta on Setup1 : LastAdaptive, 3D [Freq=2.4GHz]
  Gain Plot 2: dB(GainTotal) vs Theta on Setup1 : LastAdaptive, Infinite Sphere1 [Phi=0deg Freq=2.4GHz]
  Gain Plot 3: dB(GainTotal) vs Theta on Setup1 : Sweep, Infinite Sphere1 [Phi=0deg Freq=2.4GHz]
