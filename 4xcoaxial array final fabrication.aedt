# Ansys Electronics Desktop project, version 2022.1
materials:
  vacuum: permittivity=1
  FR4_epoxy: permittivity=4.4 dielectric_loss_tangent=0.02
  pec: conductivity=1e+30

design HFSSDesign1 (HFSS, DrivenModal, model units mm)
variables:
  l = 29.4424mm
  w = 38.0363mm
  h = 1.6mm
  lg = 6*h+l
  wg = 6*h+w
  fx = 6.7222222mm  # optimise 1.89955mm..5.69865mm
  fy = 0mm
  rout = (6.35/2) mm
  rin = (0.97/2) mm
  rd = (4.59/2) mm
  hc = 3.5mm
geometry:
  patch = rectangle(corner=(-l/2, -w/2, 0mm), x_size=l, y_size=w)
  Box1 = box(corner=(-lg/2, -wg/2, 0mm), size=(lg, wg, -h))
  ground = rectangle(corner=(-lg/2, -wg/2, -h), x_size=lg, y_size=wg)
  pin [pec] = cylinder(axis=Z, base_centre=(fx, fy, 0), radius=rin, height=-hc-h)
  dielectric = cylinder(axis=Z, base_centre=(fx, fy, -h), radius=rd, height=-hc)
  Cylinder3 = cylinder(axis=Z, base_centre=(fx, fy, 0), radius=rin, height=-hc-h)
  outer [pec] = cylinder(axis=Z, base_centre=(fx, fy, -h), radius=rout, height=-hc)
  Cylinder5 = cylinder(axis=Z, base_centre=(fx, fy, -h), radius=rd, height=-hc)
  dielectric.subtract(Cylinder3)
  outer.subtract(Cylinder5)
  Circle1 = circle(normal=Z, centre=(fx, fy, -h), radius=rout)
  ground.subtract(Circle1)
  pin1 = cylinder(axis=Z, base_centre=(fx, fy, 0), radius=rin, height=-hc-h)
  Box1.subtract(pin1)
  pecCap1 [pec] = object_from(Box1_2.edge(1 of 2))
  pecCap1.thicken(0.94mm)
  Box1_1 = Box1.duplicate_along_line(step=(39.047mm, 0mm, 0mm), total=2)
  patch_1 = patch.duplicate_along_line(step=(39.047mm, 0mm, 0mm), total=2)
  ground_1 = ground.duplicate_along_line(step=(39.047mm, 0mm, 0mm), total=2)
  dielectric_1 = dielectric.duplicate_along_line(step=(38.82836mm, 0mm, 0mm), total=2)
  pin_1 [pec] = pin.duplicate_along_line(step=(38.82836mm, 0mm, 0mm), total=2)
  pecCap1_1 [pec] = pecCap1.duplicate_along_line(step=(38.82836mm, 0mm, 0mm), total=2)
  outer_1 [pec] = outer.duplicate_along_line(step=(38.82836mm, 0mm, 0mm), total=2)
  Box1.unite(Box1_1)
  Box1.unite(dielectric_1, dielectric)
  ground.unite(ground_1)
  ground_2 = ground.duplicate_along_line(step=(0mm, 47.637mm, 0mm), total=2)
  patch_2 = patch.duplicate_along_line(step=(-0.0083913899mm, 47.637mm, 0mm), total=2)
  patch_1_1 = patch_1.duplicate_along_line(step=(-0.0083913899mm, 47.637mm, 0mm), total=2)
  Box1_2 [FR4_epoxy] = Box1.duplicate_along_line(step=(-7.4072692e-16mm, 47.637mm, 0mm), total=2)
  outer_2 [pec] = outer.duplicate_along_line(step=(0mm, 47.637mm, 0mm), total=2)
  outer_1_1 [pec] = outer_1.duplicate_along_line(step=(0mm, 47.637mm, 0mm), total=2)
  pecCap1_2 [pec] = pecCap1.duplicate_along_line(step=(0mm, 47.637mm, 0mm), total=2)
  pecCap1_1_1 [pec] = pecCap1_1.duplicate_along_line(step=(0mm, 47.637mm, 0mm), total=2)
  pin_2 [pec] = pin.duplicate_along_line(step=(0mm, 47.637mm, 0mm), total=2)
  pin_1_1 [pec] = pin_1.duplicate_along_line(step=(0mm, 47.637mm, 0mm), total=2)
  Box1_2.unite(Box1)
  ground_2.unite(ground)
  RadiatingSurface [vacuum] = region(absolute_offset=41.666667mm on all sides)
  pin2 = cylinder(axis=Z, base_centre=(fx, fy, 0), radius=rin, height=-hc-h)
  pin_3 = pin2.duplicate_along_line(step=(38.82836mm, 0mm, 0mm), total=2)
  pin2.delete()
  Box1_2.subtract(pin_3)
  pin3 = cylinder(axis=Z, base_centre=(fx, fy, 0), radius=rin, height=-hc-h)
  pin_4 = pin3.duplicate_along_line(step=(38.82836mm, 0mm, 0mm), total=2)
  pin_1_2 = pin_4.duplicate_along_line(step=(0mm, 47.637mm, 0mm), total=2)
  [pin3, pin_4].delete()
  Box1_2.subtract(pin_1_2)
  coordinate_system RelativeCS1 = origin=(19.5258mm, 23.81885mm, 0mm) x=(1mm, 0mm, 0mm) y=(0mm, 1mm, 0mm)
  coordinate_system RelativeCS2 = origin=(-19.5212mm, -23.81815mm, 0mm) x=(1mm, 0mm, 0mm) y=(0mm, 1mm, 0mm)
  coordinate_system RelativeCS3 = origin=(0mm, 0mm, -1.6mm) x=(1mm, 0mm, 0mm) y=(0mm, 1mm, 0mm) in RelativeCS2
boundaries and excitations:
  PerfE2: Perfect E Objects=patch
  PerfE3: Perfect E Objects=[outer, pin]
  PerfE5: Perfect E Objects=patch_1
  PerfE6: Perfect E Objects=[outer_1, pin_1]
  PerfE7: Perfect E Objects=ground_2
  PerfE8: Perfect E Objects=patch_2
  PerfE9: Perfect E Objects=patch_1_1
  Open1: Radiation Objects=RadiatingSurface
  1: Wave Port Faces=Box1_2.face(2 of 3) pin.face(2 of 3) NumModes=1 Modes{Mode1{IntLine{(6.7222222, 0, -5.1) -> (7689.1592mm, 2070.6767mm, -5100mm)} CharImp=Zpi}}
  2: Wave Port Faces=Box1_2.face(3 of 4) pin_1.face(2 of 3) NumModes=1 Modes{Mode1{IntLine{(45.550582, 0, -5.1) -> (46517.519mm, 2070.6767mm, -5100mm)} CharImp=Zpi}}
  3: Wave Port Faces=pin_1_1.face(2 of 3) Box1_2.face(13 of 21) NumModes=1 Modes{Mode1{IntLine{(45.550582, 47.637, -5.1) -> (47751.09mm, 46990.259mm, -5100mm)} CharImp=Zpi}}
  4: Wave Port Faces=pin_2.face(2 of 3) Box1_2.face(2 of 21) NumModes=1 Modes{Mode1{IntLine{(6.7222222, 47.637, -5.1) -> (6.7222222, 45.342, -5.1)} CharImp=Zpi}}
  reference conductors: outer
setups:
  Setup1: HfssDriven Frequency=2.4GHz MaxDeltaS=0.02 MaximumPasses=20 MinimumPasses=1 MinimumConvergedPasses=1 PercentRefinement=30 BasisOrder=1 PortAccuracy=2 DrivenSolverType="Direct Solver"
    sweep Sweep: 1.2GHz to 3.5GHz, 100 points; Type=Fast SaveFields
source amplitudes:
  1:1, 2:1, 3:1, 4:1: 5W 0deg
radiation setups:
  3D: Infinite Sphere Theta=0deg..180deg step 2deg Phi=-180deg..180deg step 2deg
  Elevation: Infinite Sphere Theta=-180deg..180deg step 1deg Phi=0deg..90deg step 90deg
  Azimuth: Infinite Sphere Theta=90deg..90deg step 0deg Phi=-180deg..180deg step 1deg
  Infinite Sphere1: Infinite Sphere Theta=0deg..180deg step 2deg Phi=-180deg..180deg step 2deg
reports:
  S Parameter Plot 1: dB(S(1,1)) vs Freq on Setup1 : Sweep [fx=all]; markers m1 at 2.3151515GHz
  Gain Plot 1: dB(GainTotal) vs Phi, Theta on Setup1 : LastAdaptive, 3D [Freq=2.4GHz fx=6.72222mm]
  Axial Ratio Plot 2: dB(AxialRatioValue) vs Freq on Setup1 : LastAdaptive, 3D [Phi=0deg Theta=0deg]
  Axial Ratio Plot 3: dB(AxialRatioValue) vs Freq on Setup1 : Sweep, 3D [Phi=0deg Theta=0deg]
