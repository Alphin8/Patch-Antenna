# Ansys Electronics Desktop project, version 2022.1
materials:
  FR4_epoxy: permittivity=4.4 dielectric_loss_tangent=0.02
  pec: conductivity=1e+30
  vacuum: permittivity=1

design HFSSDesign2 (HFSS, DrivenModal, model units mm)
variables:
  l = 29.4424mm
  w = 38.0363mm
  h = 1.6mm
  lg = 6*h+l
  wg = 6*h+w
  fx = 10.48354mm
  rout = 3.96mm
  fy = 0mm
  hc = 3.5mm
  rin = 0.6881mm
  rd = 3.325mm
geometry:
  ground = rectangle(corner=(-lg/2, -wg/2, -h), x_size=lg, y_size=wg)
  Cylinder1 [vacuum] = cylinder(axis=Y, base_centre=(0mm, -70mm, -33.6mm), radius=32mm, height=140mm)
  Cylinder1_1 = Cylinder1.copy()
  Cylinder1_1.delete()
  ground.wrap_sheet(SheetBody=50 TargetBody=84)
  Rectangle1 [FR4_epoxy] = rectangle(corner=(-lg/2, -wg/2, -h), x_size=lg, y_size=wg)
  Cylinder1_3 = Cylinder1.copy()
  Cylinder1_3.delete()
  Rectangle1.wrap_sheet(SheetBody=189 TargetBody=202)
  Rectangle1.thicken(1.6mm)
  patch = rectangle(corner=(-l/2, -w/2, 0mm), x_size=l, y_size=w)
  Rectangle1_1 = Rectangle1.copy()
  Rectangle1_1.delete()
  patch.wrap_sheet(SheetBody=312 TargetBody=331)
  pin = cylinder(axis=Z, base_centre=(fx, fy, 0), radius=rin, height=-hc-h)
  dielectric = cylinder(axis=Z, base_centre=(fx, fy, -h), radius=rd, height=-hc)
  Cylinder3 = cylinder(axis=Z, base_centre=(fx, fy, 0), radius=rin, height=-hc-h)
  dielectric.subtract(Cylinder3)
  outer = cylinder(axis=Z, base_centre=(fx, fy, -h), radius=rout, height=-hc)
  Cylinder8 = cylinder(axis=Z, base_centre=(fx, fy, -h), radius=rd, height=-hc)
  outer.subtract(Cylinder8)
  [pin, outer, dielectric].move(0mm, 0mm, -1.6mm)
  [outer, pin, dielectric].move(0mm, 0mm, -0.15mm)
  [pin, outer, dielectric].rotate(axis=Y, angle=25.9329234deg)
  [pin, outer, dielectric].move(1.4278421mm, 23.13005mm, 4.6075023mm)
  [pin, outer, dielectric].move(-0.090451609mm, -11.13005mm, -0.44906842mm)
  [pin, outer, dielectric].move(0.090451609mm, 11.13005mm, 0.44906842mm)
  [pin, dielectric, outer].move(-0.090451609mm, -9.13005mm, 0.050931584mm)
  Rectangle2 [FR4_epoxy] = rectangle(corner=(-lg/2, -wg/2, -h), x_size=lg, y_size=wg)
  Rectangle2.wrap_sheet(SheetBody=189 TargetBody=202)
  Rectangle2.thicken(1.6mm)
  Cylinder9 = cylinder(axis=Y, base_centre=(0mm, -70mm, -33.6mm), radius=32mm, height=140mm)
  Cylinder1_4 = Cylinder9.copy()
  [Cylinder9, Cylinder1_4].delete()
  Rectangle3 [FR4_epoxy] = rectangle(corner=(-lg/2, -wg/2, -h), x_size=lg, y_size=wg)
  Rectangle3.wrap_sheet(SheetBody=189 TargetBody=202)
  Rectangle3.thicken(1.6mm)
  Cylinder10 = cylinder(axis=Y, base_centre=(0mm, -70mm, -33.6mm), radius=32mm, height=140mm)
  Cylinder1_5 = Cylinder10.copy()
  [Cylinder10, Cylinder1_5].delete()
  Rectangle4 [FR4_epoxy] = rectangle(corner=(-lg/2, -wg/2, -h), x_size=lg, y_size=wg)
  Rectangle4.wrap_sheet(SheetBody=189 TargetBody=202)
  Rectangle4.thicken(1.6mm)
  Cylinder11 = cylinder(axis=Y, base_centre=(0mm, -70mm, -33.6mm), radius=32mm, height=140mm)
  Cylinder1_6 = Cylinder11.copy()
  [Cylinder11, Cylinder1_6].delete()
  outer1 = cylinder(axis=Z, base_centre=(fx, fy, -h), radius=rout, height=-hc)
  Cylinder12 = cylinder(axis=Z, base_centre=(fx, fy, -h), radius=rd, height=-hc)
  outer1.subtract(Cylinder12)
  outer1.move(0mm, 0mm, -1.6mm)
  outer1.move(0mm, 0mm, -0.15mm)
  outer1.rotate(axis=Y, angle=25.9329234deg)
  outer1.move(1.4278421mm, 23.13005mm, 4.6075023mm)
  outer1.move(-0.090451609mm, -11.13005mm, -0.44906842mm)
  outer1.move(0.090451609mm, 11.13005mm, 0.44906842mm)
  outer1.move(-0.090451609mm, -9.13005mm, 0.050931584mm)
  Rectangle2.subtract(outer1)
  pin1 = cylinder(axis=Z, base_centre=(fx, fy, 0), radius=rin, height=-hc-h)
  pin1.move(0mm, 0mm, -1.6mm)
  pin1.move(0mm, 0mm, -0.15mm)
  pin1.rotate(axis=Y, angle=25.9329234deg)
  pin1.move(1.4278421mm, 23.13005mm, 4.6075023mm)
  pin1.move(-0.090451609mm, -11.13005mm, -0.44906842mm)
  pin1.move(0.090451609mm, 11.13005mm, 0.44906842mm)
  pin1.move(-0.090451609mm, -9.13005mm, 0.050931584mm)
  Rectangle3.subtract(pin1)
  dielectric1 = cylinder(axis=Z, base_centre=(fx, fy, -h), radius=rd, height=-hc)
  Cylinder13 = cylinder(axis=Z, base_centre=(fx, fy, 0), radius=rin, height=-hc-h)
  dielectric1.subtract(Cylinder13)
  dielectric1.move(0mm, 0mm, -1.6mm)
  dielectric1.move(0mm, 0mm, -0.15mm)
  dielectric1.rotate(axis=Y, angle=25.9329234deg)
  dielectric1.move(1.4278421mm, 23.13005mm, 4.6075023mm)
  dielectric1.move(-0.090451609mm, -11.13005mm, -0.44906842mm)
  dielectric1.move(0.090451609mm, 11.13005mm, 0.44906842mm)
  dielectric1.move(-0.090451609mm, -9.13005mm, 0.050931584mm)
  Rectangle4.subtract(dielectric1)
  Cylinder14 [vacuum] = cylinder(axis=Y, base_centre=(0mm, -70mm, -33.6mm), radius=32mm, height=140mm)
  Cylinder15 [vacuum] = cylinder(axis=Y, base_centre=(0mm, -70mm, -33.6mm), radius=32mm, height=140mm)
  Cylinder16 [vacuum] = cylinder(axis=Y, base_centre=(0mm, -70mm, -33.6mm), radius=32mm, height=140mm)
  Cylinder14.subtract(outer)
  Cylinder15.subtract(pin)
  Cylinder16.subtract(dielectric)
boundaries and excitations:
  PerfE1: Perfect E Objects=ground
  PerfE2: Perfect E Objects=patch
